* extracted by klt extract --deck sky130

* cell ota_5t_layout_0
* pin N1
* pin TAIL_A,TAIL_B
* pin VOUT
* pin vsubs
.SUBCKT ota_5t_layout_0 N1 TAIL_A|TAIL_B VOUT vsubs
* device instance $1 r0 *1 6.1,3 nfet
M$1 \$2 \$7 N1 vsubs nfet L=1U W=6U AS=2.52P AD=2.52P PS=12.84U PD=12.84U
* device instance $2 r0 *1 3.51,4 nfet
M$2 N1 \$8 TAIL_A|TAIL_B vsubs nfet L=0.5U W=8U AS=3.36P AD=3.36P PS=16.84U
+ PD=16.84U
* device instance $3 r0 *1 0.92,5 nfet
M$3 TAIL_A|TAIL_B \$9 \$3 vsubs nfet L=1U W=10U AS=4.2P AD=4.2P PS=20.84U
+ PD=20.84U
* device instance $4 r0 *1 6.1,9.4 nfet
M$4 \$6 \$10 VOUT vsubs nfet L=1U W=6U AS=2.52P AD=2.52P PS=12.84U PD=12.84U
* device instance $5 r0 *1 3.51,12.4 nfet
M$5 VOUT \$11 TAIL_A|TAIL_B vsubs nfet L=0.5U W=8U AS=3.36P AD=3.36P PS=16.84U
+ PD=16.84U
.ENDS ota_5t_layout_0
