* klt pex testbench for the sky130 5T OTA composed layout (06-layout.gds),
* Epic #709 Phase 1c (#803) -- the same connectivity/bias network
* 09-sim.testbench.spice already proved closes the extract -> sim loop
* (see that file's own comments for why `.options rshunt=1e12` is needed
* and why `nfet` is a generic device-class model, not a PDK-specific
* flavor), reused here so `klt pex` can drive both legs of the
* schematic-vs-extracted delta from one request.
*
* `.include`s the schematic-equivalent DUT: 07-reference.spice, the same
* hand-written netlist 08-lvs.result.json already verified is
* topologically LVS-clean against 06-layout.gds (`status: "match"`), so it
* is a faithful "ideal, no parasitics" stand-in for this composed layout's
* actual 5-device connectivity graph -- not the full PMOS-input-pair 5T OTA
* schematic (ota_5t.spice); see this file's own README section
* "S10 pex delta proof" for why those two schematics differ and which one
* `klt pex`'s DUT-swap convention needs here. `klt pex` rewrites this one
* `.include` line to point at its own freshly `--parasitics`-extracted
* netlist for the extracted-side leg; the schematic-side leg runs this
* file completely unmodified.
.model nfet nmos level=1
.options rshunt=1e12
.param vn1=1.0
.include "07-reference.spice"

Vvsubs vsubs    0 DC 0
Vn1    n1_node  0 DC {vn1}
Vtail  tail_node 0 DC 0.5
Vvout  vout_node 0 DC 1.0
Xota n1_node tail_node vout_node vsubs ota_5t_layout_0
