* klt pex testbench for the sky130 5T OTA composed layout (06-layout.gds),
* Epic #709 Phase 3b (#989) -- a genuinely current-carrying companion to
* 10-pex.testbench.spice's Phase 1c bias-probe scope.
*
* 10-pex.testbench.spice's own bias network (Vn1=1.0V, Vtail=0.5V,
* Vvout=1.0V) drives every measured node directly from an ideal DC source at
* that net's own star hub, and the composed layout's `nfet` device model has
* the generic SPICE level=1 default threshold VTO=0 with every gate
* ($7/$8/$9/$10/$11 in the extracted netlist, g1-g5 in 07-reference.spice)
* floating (klt gen-compose never routes a generator's gate/unconnected
* source-drain port through connectivity[] -- see this file's own README
* "Friction encountered" section) -- `.options rshunt=1e12` (below) is the
* *only* DC path any gate has, so every gate settles at exactly 0V
* regardless of bias. With VTO=0, biasing this same TAIL_A|TAIL_B net
* *negative* instead of positive makes every device whose gate sits at 0V
* and whose *source* is the TAIL net see Vgs = 0 - (negative) > 0 = VTO --
* turning that device ON. Two of this composed layout's five devices are
* wired exactly that way: the M2-equivalent instance ($2, s=TAIL_A|TAIL_B,
* g=$8, d=N1) and the M5-equivalent instance ($5, s=TAIL_A|TAIL_B, g=$11,
* d=VOUT) -- both source-side terminals on TAIL_A|TAIL_B, both drain-side
* terminals on an *actively driven* pin net (N1, VOUT respectively), so
* turning them on completes a genuine external-source-to-external-source DC
* current loop through TAIL_A|TAIL_B's own star-arm resistors -- unlike the
* internal-only $2/$3/$6 star nodes (Epic #709 Phase 3b's own curator note),
* which are single-device dead ends (one series R then one ground C, no
* other element) that carry zero current in DC steady state *regardless* of
* bias, since a capacitor blocks all DC current and there is no other path
* off that node. See examples/design-pipeline/README.md's "S10 mom-fed pex
* delta proof" section for the full derivation and the actual measured
* currents this produces.
*
* Same `.include`/`.options`/`.model` conventions as 09-sim.testbench.spice/
* 10-pex.testbench.spice -- only the TAIL bias's sign changes.
.model nfet nmos level=1
.options rshunt=1e12
.param vtail=-0.5
.include "07-reference.spice"

Vvsubs vsubs    0 DC 0
Vn1    n1_node  0 DC 1.0
Vtail  tail_node 0 DC {vtail}
Vvout  vout_node 0 DC 1.0
Xota n1_node tail_node vout_node vsubs ota_5t_layout_0
