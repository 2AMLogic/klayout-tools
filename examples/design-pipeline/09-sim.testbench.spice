* Post-extraction testbench for the sky130 5T OTA composed layout
* (06-layout.gds -> 07-extract.spice). `.include`s the extracted circuit
* body UNMODIFIED (per Epic #153's acceptance bar, "klt extract output feeds
* klt sim unmodified") and biases it through its own declared .SUBCKT pins
* (N1 / TAIL_A|TAIL_B / VOUT / vsubs -- see 07-extract.spice's ".SUBCKT"
* line). No `.control`/`.end` card -- klt sim generates the corner wrapper.
*
* `nfet` is klt extract's generic device-class model name, not a
* PDK-specific flavor (docs/cli/extract.md) -- a plain level=1 model is
* enough to prove the extract -> sim loop closes; this is not a
* transistor-level electrical characterization of the OTA (that already
* happened at the schematic level in sim-ac.result.json/sim-op.result.json,
* S10 Loop A). Per #205's documented workaround, `.options rshunt=1e12`
* gives every node (including this composition's floating gate/source
* terminals -- klt gen's own per-generator ports, never wired through
* connectivity[] in 06-layout.request.json) a real DC path so ngspice's
* solver converges cleanly with no `singular matrix` diagnostic.
*
* Still required after issue #1263: `klt extract --parasitics` now writes
* its own `Rvsubs_dctie vsubs 0 1e12` DC reference into the extracted
* .SUBCKT body, which covers the *substrate* net -- but not this
* composition's floating gate/source terminals, which have no other DC path
* at all. `.options rshunt` stays; it is idempotent with the extraction's
* own tie (see docs/cli/extract.md, "Substrate DC reference").
.model nfet nmos level=1
.options rshunt=1e12
.param vn1=1.0
.include "07-extract.spice"

Vvsubs vsubs    0 DC 0
Vn1    n1_node  0 DC {vn1}
Vtail  tail_node 0 DC 0.5
Vvout  vout_node 0 DC 1.0
Xota n1_node tail_node vout_node vsubs ota_5t_layout_0
