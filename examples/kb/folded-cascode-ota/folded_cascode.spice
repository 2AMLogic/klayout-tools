* Folded-cascode OTA (NMOS input pair, folded into PMOS folding sources +
* PMOS cascode devices, combined at an NMOS cascode current mirror).
* sky130 schematic-level netlist BODY -- no .control/.end (klt sim wraps this).
* Device W/L are in microns (sky130_fd_pr subckt convention: D G S B).
*
* Topology, node by node (matches kb/entries/folded-cascode-ota.json's own
* topology text):
*   - MNBT/MN0: NMOS tail current sink (diode-referenced, same pattern as
*     five-transistor-ota's own tail bias), sinks ~itail from the input
*     pair's common source node "tail" to ground.
*   - M1/M2: NMOS input differential pair, drains at fold nodes f1/f2.
*   - MPBF/MF1/MF2: PMOS folding current sources (diode-referenced),
*     each sourcing ~ifold (> itail/2, so the folding branch is never
*     starved) into f1/f2.
*   - MC1/MC2: PMOS folding cascode devices -- "cascode transistors of the
*     opposite type" the entry's topology names -- source=f1/f2, drain=
*     y1/out. Each carries (ifold - I_M1) / (ifold - I_M2), the folded
*     difference current, up to y1/out.
*   - MNC1/MNC2 + MNM1/MNM2: NMOS cascode current mirror. MNM1 is
*     diode-connected (self-biasing); MNM2 mirrors it 1:1. This is the
*     "cascoded current mirror" the topology text names: it forces branch 2
*     (y2/out) to try to sink the SAME current branch 1 sinks, so any
*     difference between the two folded branch currents (the differential
*     signal) has nowhere to go except into node "out" itself -- this is
*     the single-ended-conversion mechanism, and "out" is the amplifier's
*     high-impedance output node.
*
* Open-loop gain is characterized with the same DC-feedback-loop-opening
* technique five-transistor-ota/ota_5t.spice uses: Lfb/Cfb hold out=vcm at
* DC while opening the loop at AC, so v(out)/vac is the open-loop transfer.
*
* Cascode gate bias generation (pcasc, ncasc) uses independent
* diode-connected replica stacks (XMPBF_REF/XMPBC_REF for pcasc;
* XMNREFA/XMNREFB for ncasc), each carrying a small reference current
* {ipcasc}/{incasc} close to a folded branch's actual excess current
* (ifold - itail/2), rather than a full wide-swing bias-generation network
* -- the entry's own sizing_approach flags "wide-swing (low-voltage)
* cascode bias generation" as a further refinement on top of this core
* topology, not a prerequisite for measuring its open-loop AC response.
* This still self-biases each cascode gate at the Vgs its own
* MC1/MC2-or-MNC1/MNC2-sized device needs at roughly the current it will
* actually carry, rather than guessing a fixed voltage. Every device in
* this netlist (signal path and bias generation alike) is a real
* sky130_fd_pr__nfet_01v8/pfet_01v8 device; only the four current
* references (Iref_tail, Iref_fold, Iref_pcasc, Iref_ncasc) are ideal DC
* current sources, the same convention five-transistor-ota's own Iref uses.
.param vdd=1.8
.param vcm=0.95
.param itail=40u
.param ifold=26u
.param ipcasc=8u
.param incasc=8u
.param cl=1p

* --- supplies and stimulus ---
Vdd  vdd 0 DC {vdd}
Vcm  cm  0 DC {vcm}
Vin  inp cm DC 0 AC 1
CL   out 0 {cl}

* --- DC feedback: closes at DC to bias out=vcm, opens at AC ---
Lfb  out inn 1e9
Cfb  inn cm  1e3

* --- tail current sink (NMOS, same bias-mirror pattern as five-transistor-ota) ---
Iref_tail vdd nbias_tail DC {itail}
XMNBT nbias_tail nbias_tail 0 0 sky130_fd_pr__nfet_01v8 L=1 W=10 nf=1 mult=1
XMN0  tail       nbias_tail 0 0 sky130_fd_pr__nfet_01v8 L=1 W=10 nf=1 mult=1

* --- input differential pair (NMOS) ---
XM1  f1  inp tail 0 sky130_fd_pr__nfet_01v8 L=0.5 W=8 nf=1 mult=1
XM2  f2  inn tail 0 sky130_fd_pr__nfet_01v8 L=0.5 W=8 nf=1 mult=1

* --- folding current sources (PMOS) ---
Iref_fold pbias_fold 0 DC {ifold}
XMPBF pbias_fold pbias_fold vdd vdd sky130_fd_pr__pfet_01v8 L=3 W=80 nf=3 mult=1
XMF1  f1  pbias_fold vdd vdd sky130_fd_pr__pfet_01v8 L=3 W=80 nf=3 mult=1
XMF2  f2  pbias_fold vdd vdd sky130_fd_pr__pfet_01v8 L=3 W=80 nf=3 mult=1

* --- folding cascode transistors (PMOS) ---
* pcasc is generated by an independent replica stack (MPBF_REF diode-atop-
* MPBC_REF diode) carrying {ipcasc}, a reference current close to each
* folding branch's actual excess current (ifold - itail/2) rather than
* the full {ifold} -- self-biasing the cascode gate at the Vsg its own
* MC1/MC2-sized device needs at roughly the current it will actually carry
* (a full replica of the actual Mf1+Mc1 series stack was tried first and
* forces both diodes to the same ifold, driving MC1/MC2's smaller-W
* replica into an unrealistically large Vsg -- decoupling the reference
* current from ifold avoids that).
XMPBF_REF pref  pref  vdd  vdd sky130_fd_pr__pfet_01v8 L=3 W=80 nf=3 mult=1
XMPBC_REF pcasc pcasc pref vdd sky130_fd_pr__pfet_01v8 L=3 W=60 nf=2 mult=1
Iref_pcasc pcasc 0 DC {ipcasc}
XMC1  y1  pcasc f1 vdd sky130_fd_pr__pfet_01v8 L=3 W=60 nf=2 mult=1
XMC2  out pcasc f2 vdd sky130_fd_pr__pfet_01v8 L=3 W=60 nf=2 mult=1

* --- NMOS cascode current mirror (combines the two folded branches) ---
* ncasc is generated by MNREFA/MNREFB, a diode-connected replica of
* MNM1/MNC1 stacked at a smaller reference current {incasc} sized to match
* each folded branch's expected excess current (ifold - itail/2).
Iref_ncasc vdd ncasc_top DC {incasc}
XMNREFB ncasc_top ncasc_top nb_ref     0 sky130_fd_pr__nfet_01v8 L=3 W=60 nf=2 mult=1
XMNREFA nb_ref    nb_ref   0           0 sky130_fd_pr__nfet_01v8 L=3 W=60 nf=2 mult=1
XMNC1 y1  ncasc_top z1 0 sky130_fd_pr__nfet_01v8 L=3 W=60 nf=2 mult=1
XMNC2 out ncasc_top z2 0 sky130_fd_pr__nfet_01v8 L=3 W=60 nf=2 mult=1
XMNM1 z1  z1   0  0 sky130_fd_pr__nfet_01v8 L=3 W=60 nf=2 mult=1
XMNM2 z2  z1   0  0 sky130_fd_pr__nfet_01v8 L=3 W=60 nf=2 mult=1
