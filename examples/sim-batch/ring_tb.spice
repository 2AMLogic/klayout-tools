* Epic #253 / #277 validation testbench: 31-stage sky130 ring oscillator
* (no .control/.end -- klt sim generates those)
* Heavy transient load per corner, standing in for the measured 5-corner
* gf180 matrix (gf180 corner bundles not yet expressible -- see #351).
* Frequency varies strongly with process corner => real per-corner
* measurement with wide sanity limits.
.param vdd=1.8

.subckt inv in out vp vn
XM1 out in vn vn sky130_fd_pr__nfet_01v8 w=1 l=0.15
XM2 out in vp vp sky130_fd_pr__pfet_01v8 w=2 l=0.15
.ends

Vdd vdd 0 DC {vdd}

* 31-stage ring
Xinv0 n30 n0 vdd 0 inv
Xinv1 n0 n1 vdd 0 inv
Xinv2 n1 n2 vdd 0 inv
Xinv3 n2 n3 vdd 0 inv
Xinv4 n3 n4 vdd 0 inv
Xinv5 n4 n5 vdd 0 inv
Xinv6 n5 n6 vdd 0 inv
Xinv7 n6 n7 vdd 0 inv
Xinv8 n7 n8 vdd 0 inv
Xinv9 n8 n9 vdd 0 inv
Xinv10 n9 n10 vdd 0 inv
Xinv11 n10 n11 vdd 0 inv
Xinv12 n11 n12 vdd 0 inv
Xinv13 n12 n13 vdd 0 inv
Xinv14 n13 n14 vdd 0 inv
Xinv15 n14 n15 vdd 0 inv
Xinv16 n15 n16 vdd 0 inv
Xinv17 n16 n17 vdd 0 inv
Xinv18 n17 n18 vdd 0 inv
Xinv19 n18 n19 vdd 0 inv
Xinv20 n19 n20 vdd 0 inv
Xinv21 n20 n21 vdd 0 inv
Xinv22 n21 n22 vdd 0 inv
Xinv23 n22 n23 vdd 0 inv
Xinv24 n23 n24 vdd 0 inv
Xinv25 n24 n25 vdd 0 inv
Xinv26 n25 n26 vdd 0 inv
Xinv27 n26 n27 vdd 0 inv
Xinv28 n27 n28 vdd 0 inv
Xinv29 n28 n29 vdd 0 inv
Xinv30 n29 n30 vdd 0 inv

* per-stage load caps to slow the ring and thicken the matrix
C0 n0 0 20f
C1 n1 0 20f
C2 n2 0 20f
C3 n3 0 20f
C4 n4 0 20f
C5 n5 0 20f
C6 n6 0 20f
C7 n7 0 20f
C8 n8 0 20f
C9 n9 0 20f
C10 n10 0 20f
C11 n11 0 20f
C12 n12 0 20f
C13 n13 0 20f
C14 n14 0 20f
C15 n15 0 20f
C16 n16 0 20f
C17 n17 0 20f
C18 n18 0 20f
C19 n19 0 20f
C20 n20 0 20f
C21 n21 0 20f
C22 n22 0 20f
C23 n23 0 20f
C24 n24 0 20f
C25 n25 0 20f
C26 n26 0 20f
C27 n27 0 20f
C28 n28 0 20f
C29 n29 0 20f
C30 n30 0 20f

* kick to start oscillation
Ikick 0 n0 PULSE(0 10u 1n 1n 1n 2n 1)

.ic v(n0)=0
.options reltol=1e-4
