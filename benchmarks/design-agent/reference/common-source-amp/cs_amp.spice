* Reference solution for benchmarks/design-agent/tasks/common-source-amp.json.
*
* Common-source NMOS amplifier: resistive drain load, drain-to-gate
* feedback resistor for a process/temperature-robust self-bias point
* (Id = (Vdd-Vout)/Rd with Vgate=Vout at DC, since no DC current flows in
* the gate branch -- negative feedback that survives the Vt/KP corner
* sweep below without a fixed external bias generator), and an AC-coupled
* input so the feedback loop's DC operating point is undisturbed by the
* input source.
*
* Circuit body only: no .control/.end cards (klt sim generates those --
* see docs/cli/sim.md, "Netlist convention"). Real sky130 devices
* (sky130_fd_pr__nfet_01v8) via $PDK_ROOT, per docs/cli/sim.md -- see
* sim_request.json's "models" field. Device W/L are in microns
* (sky130_fd_pr subckt convention, bare numbers not "u"-suffixed).

.param vdd=1.8
.param rd=10k
.param rf=300k
.param cin=1u

Vdd vdd 0 DC {vdd}
Vin in 0 DC 0 AC 1
Cin in gate {cin}
Rf out gate {rf}
XMn out gate 0 0 sky130_fd_pr__nfet_01v8 L=2 W=15 nf=1 mult=1
Rd vdd out {rd}
