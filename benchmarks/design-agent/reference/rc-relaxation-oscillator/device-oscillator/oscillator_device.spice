* Device-level sky130 relaxation oscillator assembled around the
* split-polarity comparator core (issue #1813/#1815), per issue #1814.
*
* NOT the benchmark's reference solution. The shipped reference solution
* for benchmarks/design-agent/tasks/rc-relaxation-oscillator.json remains
* the behavioral ../oscillator.spice -- see README.md here for the explicit
* "replace vs. ship alongside" decision this issue asks for (ship
* alongside; this file is an additional device-level variant).
*
* -------------------------------------------------------------------
* What this file assembles (the four pieces
* docs/design/relaxation-oscillator-comparator-core-spike.md's "What is
* deliberately still missing" section named):
* -------------------------------------------------------------------
*   1. Charge/discharge current source + timing capacitor (Cosc/Rleak/
*      XMchg+XSWchg/XMdis+XSWdis below) -- a real sky130 current-mirror
*      equivalent of ../oscillator.spice's ideal Biosc element, mirrored
*      off the same nbias/pbias rails the comparator core already uses,
*      switched on/off by the SR latch's q output.
*   2. Output edge-combination logic (the cross-coupled NOR SR latch +
*      inverter below) -- turns cmp_n/cmp_p's ohi/olo into a single q/qb
*      clock pair that flips on whichever threshold is currently crossed.
*   3. A device-level reference generator for vth_lo/vth_hi (XMref +
*      Rdiv2/Rdiv1 below) -- see "Reference generator: a documented
*      simpler stand-in, not a full bandgap" below for why this is not a
*      full Banba-style bandgap.
*   4. Full 18-corner oscillation validation -- see sim_request.json and
*      README.md's Evidence section.
*
* Item 5 (#1795) is now partly addressed: the reference divider is
* temperature-coefficient compensated (see "Zero-TC composite divider"
* below). The PTAT/CTAT *bias generator* half of item 5 is still not
* here, and -- see that section -- would not have helped anyway.
*
* -------------------------------------------------------------------
* Comparator core: reused verbatim, not modified
* -------------------------------------------------------------------
* The cmp_n/cmp_p .subckt bodies and their nbias/pbias bias generation
* below are copied byte-for-byte from
* ../comparator-core/comparator_core.spice (the validated, 18/18-corner
* split-polarity topology) so this file stays a single self-contained
* circuit body -- see docs/cli/sim.md's "circuit body, not a full deck"
* convention. Nothing about the comparator core itself changes: its own
* headroom fix (issue #1813) is out of scope for this issue to touch.
*
* -------------------------------------------------------------------
* Reference generator: a documented simpler stand-in, not a full bandgap
* -------------------------------------------------------------------
* kb/entries/sky130-bandgap-reference.json's own artifact
* (examples/kb/sky130-bandgap-reference/testbench.spice) is itself a
* behavioral stand-in -- "ideal diodes/current sources", not sky130's
* real parasitic PNP devices (see that entry's own `measured.notes`). A
* genuinely device-level, curvature-corrected Banba bandgap (real
* sky130_fd_pr__pnp_05v5 devices, trimmed PTAT/CTAT resistor ratios) does
* not exist anywhere in this repo yet and is a substantial standalone
* design effort in its own right -- explicitly out of scope for #1814's
* "assemble an oscillator" increment, and still not here after #1795.
*
* Instead: XMref mirrors the SAME nbias/pbias-derived {ib} current the
* comparator core's own bias uses into a divider string referenced to
* ground, producing two real, device-set (not ideal-DC-source) absolute
* node voltages:
*   vth_lo = ib * r1
*   vth_hi = ib * (r1 + r2)
* This is a genuine improvement over the spike's ideal Vrl/Vrh sources
* (the thresholds now depend on real MOSFET mirror + real resistor
* devices, and show real PVT sensitivity in the corner sweep below) at
* far lower complexity than a full bandgap. It does NOT get the
* first-order supply cancellation a trimmed bandgap would
* (kb/entries/sky130-bandgap-reference.json's whole point) -- but it
* does now get first-order *temperature* cancellation, from the
* composite construction described next.
*
* -------------------------------------------------------------------
* Zero-TC composite divider (issue #1795)
* -------------------------------------------------------------------
* Why a PTAT/CTAT bias generator is the WRONG lever here. Iref/Irefp are
* ideal DC sources (as they are in ../comparator-core/comparator_core.
* spice, which this file reuses verbatim), and {ib} cancels out of the
* period algebraically rather than setting it -- both the threshold
* spacing and the charge current are derived from the same {ib}:
*   dV    = ib * r2
*   iosc  = k * ib             (k = XMchg/XMdis mirror ratio, ~1.95)
*   T     = 2 * cosc * dV / iosc = 2 * cosc * r2 / k
* {ib} is absent from the final expression. Giving {ib} a deliberate
* PTAT or CTAT shape -- issue #1795's originally-scoped fix, and option
* (b) of README.md's own Handoff section -- therefore moves the period
* only through second-order terms; it cannot cancel what dominates.
* What survives the cancellation is r2 ALONE, so the period carries r2's
* temperature coefficient and nothing else does. Compensating r2 itself
* is the only first-order lever, and it needs no new active circuitry.
*
* Each leg is therefore built as a series composite of a NEGATIVE-tempco
* poly resistor and a POSITIVE-tempco n-diffusion resistor, the standard
* zero-TC construction:
*   sky130_fd_pr__res_xhigh_po   rsheet 2000 ohm/sq, tc1 = -1.47e-3 /C
*   sky130_fd_pr__res_generic_nd rsheet  120 ohm/sq, tc1 = +1.422e-3 /C
* Choice of partner device. res_generic_nd's tc2 (+6.57e-7) is the
* closest curvature match to res_xhigh_po's (+2.7e-6) of anything the
* sky130.lib tt/ss/ff sections actually reach, and its body terminal is
* the p-well (ground), which the po device's own sub terminal already
* uses. res_generic_pd (197 ohm/sq) would be 37% shorter for the same
* resistance but leaves ~1.6% residual bow instead of ~1.2%, and needs
* its n-well body routed to vdd. res_iso_pw -- the obvious high-sheet
* (3816 ohm/sq), high-tempco (+3.53e-3 /C) candidate -- is NOT reachable:
* it is only included from sky130A's all.spice, never from the tt/ss/ff
* .lib sections this benchmark's sim_request.json selects. Verified by
* include-tree inspection on sky130A f6eeac7, 2026-09-18.
*
* Split ratio, measured not assumed. Forcing 5 uA through each device
* standalone against the real tt models (ngspice-46, sky130A f6eeac7)
* gives, normalised to 27 C:
*   res_xhigh_po   -40C 1.11045   27C 1.0   125C 0.88185
*   res_generic_nd -40C 0.90755   27C 1.0   125C 1.14846
* Equalising the -40 C and 125 C endpoints of p*po + (1-p)*nd gives
* p = 0.5131, i.e. the poly device carries ~51.3% of each leg's
* resistance and the n-diffusion device ~48.7%. The residual is a
* +1.17% bow (both endpoints high, 27 C low) against the 25.9% swing of
* the all-poly divider it replaces -- a 22x reduction in the divider's
* own temperature term.
*
* Cost, stated plainly: n-diffusion is 17x less resistive per square
* than xhigh poly, so the compensating sections are long -- 308 um and
* 726 um at W = 1 um, about 1030 um^2 of extra diffusion. That is the
* price of the construction, not an oversight; res_generic_pd would trade
* ~35% of it against a worse residual bow, and raising {ib} while
* shrinking every resistance (and the XMchg/XMdis mirror ratio with it)
* would trade it against re-validating the comparator core at a bias
* point #1813 did not sign off on. Neither trade was taken here.
*
* Total resistances were re-centred at the same time: the 27 C dV moves
* from 0.827 V to ~0.854 V so the (now nearly flat) period sits closer to
* the 1.4-2.2 us band's geometric centre instead of at its old 27 C
* value. vth_lo is held at its old 27 C value (~0.362 V) so both
* comparators keep the common-mode they were validated at.
*
* No positive-feedback or regenerative element is introduced anywhere by
* this change -- it is four passive two-terminal devices replacing two.
* The only new nodes are the two series-junction nodes rmid1/rmid2.
*
* -------------------------------------------------------------------
* Charge/discharge current source + SR-latch switching
* -------------------------------------------------------------------
* XMchg (PMOS, mirrored off pbias) sources iosc into node vo through
* PMOS switch XSWchg, gated by q (ON when q=0, i.e. "charge" state).
* XMdis (NMOS, mirrored off nbias) sinks iosc from node vo through NMOS
* switch XSWdis, gated by q (ON when q=1, i.e. "discharge" state) -- one
* control signal drives both switches because PMOS/NMOS switches are ON
* at opposite gate polarities. Whichever switch is enabled dominates the
* other's (large, ~1 Gohm) off-state leakage by many orders of magnitude,
* so at most one of charge/discharge is ever effectively active.
*
* The SR latch (2 cross-coupled NOR gates, standard CMOS complementary
* stacks) takes S=ohi (pulses HIGH when vo crosses vth_hi, per
* comparator_core.spice's own "out is HIGH when in > vref" convention)
* and R=NOT(olo) (an explicit inverter, since olo pulses LOW -- not
* high -- when vo drops below vth_lo, and a NOR latch's reset input needs
* an active-HIGH pulse):
*   S=1 (hit vth_hi) -> q=1 -> switch to discharge
*   R=1 (dropped below vth_lo) -> q=0 -> switch to charge
*
* -------------------------------------------------------------------
* Start-up: no kick source, and NOT because .op lands on a latch state
* -------------------------------------------------------------------
* Unlike ../oscillator.spice, this netlist has no Istart-equivalent
* start-up kick. It does not need one -- but the reason is not that the
* SR latch's bistability makes ngspice's .op pick one of the two valid
* latch states. Re-measured at ss/1.62V/-40C after the #1795 divider
* change, .op leaves the latch itself *unresolved*: v(q) at t=0 is
* 0.5726 V, mid-rail, neither state.
*
* What actually self-starts it is the timing node, not the latch. The
* same .op leaves vo at 1.2276 V -- *outside* the threshold band
* (vth_hi = 1.2217 V there), because with both charge and discharge
* mirrors partially on and only Rleak to ground, the balance point .op
* finds for vo is not between the thresholds. So at t=0 cmp_n is
* asserting ohi, the latch's own positive feedback resolves q, and the
* first rising edge on q lands at t = 64.5 ns (measured). All 18 corners
* reach four clean steady-state edges after the 6 us measurement gate,
* which is only possible if every one of them started -- see README.md's
* Evidence section; it is measured, not assumed.
*
* What the #1795 compensation changed here: that vo - vth_hi gap is now
* 5.9 mV at ss/1.62V/-40C and 1.2-2.3 mV at 1.62V/27C (tt/ss/ff), where
* the all-poly divider left 59.8 mV. Start-up does not actually hang on
* those millivolts -- the .op solution is an *unstable* equilibrium, this
* topology has no stable DC state, so any perturbation diverges into
* oscillation.
*
* Issue #2156 measured that rather than leaving it argued. The gap is a
* feedback-loop DC residual, not a headroom offset can eat: a deliberate
* input-referred offset moves vo and the effective threshold together,
* so over voffhi = -50..+50 mV the .op margin moves by only 0.37-0.69 mV
* at the three 27C corners (10.6 mV at ss/-40C, the loosest) and never
* changes sign (see "Comparator input-referred offset injection"
* below, and README.md for the per-corner table). All 44
* deterministic offset cases in sim_request_startup_offset.json and all
* 128 mismatch Monte Carlo samples in sim_request_startup_mismatch.json
* start and reach sustained oscillation; README.md's "Start-up under
* comparator offset and mismatch" section has the numbers.
*
* Two consequences for the testbench, both handled in sim_request.json:
*   - The first fraction of a microsecond is a start-up transient, not
*     oscillation. Every edge measurement is TD-gated to start at 6 us so
*     no start-up edge can land in a reported period.
*   - Before that gate was added, the *number* of q crossings inside the
*     start-up transient was integration-timestep-dependent (a 5 ns
*     maxstep saw two extra crossings at ss/1.62V/-40C that a 2 ns
*     maxstep did not), which made any RISE=<n>-indexed measurement
*     counted from t=0 fragile. TD-gating removes that dependence: a
*     period is the gap between two consecutive steady-state edges no
*     matter what index they carry.
*
* -------------------------------------------------------------------
* Expected solver diagnostics (benign, and not this topology's fault)
* -------------------------------------------------------------------
* 16 of 18 corners report "Warning: Dynamic gmin stepping failed" (and
* "True gmin stepping failed") during the DC operating-point solve.
* Source stepping then completes and the .tran runs cleanly at all 18.
*
* All 18 report "Warning: sky130_fd_pr__diode_pw2nd_05v5: IKR too small -
* model effect disabled!" -- the high-injection knee-current parameter of
* the parasitic p-well/n-diffusion junction diodes inside
* sky130_fd_pr__res_generic_nd. Those diodes are reverse-biased by
* construction here, so the disabled term is irrelevant to this circuit;
* the warning belongs to the shipped model card.
*
* "Warning: singular matrix: check node vth_lo", which about half the
* corners emitted before the #1795 divider change, is now gone at all 18.
* It was attributable to the sky130 resistor model, not to this circuit:
* sky130_fd_pr__res_xhigh_po models its body resistance as a
* bias-dependent expression containing abs(v(t1,t2)), whose Jacobian is
* discontinuous at exactly zero bias -- which is where gmin/source
* stepping starts from. The plain, bias-independent res_generic_nd
* section now in series with each poly section keeps the node conditioned
* through that crossing. Side effect, not a design goal; the shipped
* netlist still keeps the real resistor devices rather than ideal Rs.
*
* Circuit body only: no .control/.end cards (klt sim generates those --
* see docs/cli/sim.md). Real sky130 devices via $PDK_ROOT. Device W/L in
* microns (sky130_fd_pr subckt convention, bare numbers not "u"-suffixed).

.param vdd=1.8
.param ib=5u
.param cosc=10p
* Reference-divider resistors. r1 sets vth_lo = ib*r1, r2 sets
* vth_hi-vth_lo = ib*r2, and each of r1/r2 is now a series composite of a
* negative-tempco poly section and a positive-tempco n-diffusion section
* (see "Zero-TC composite divider" above). Measured per-micron
* resistances at 27 C, W = 1 um, from a 5 uA forced-current sweep against
* the real tt models: res_xhigh_po 2118.6 ohm/um, res_generic_nd
* 117.49 ohm/um. Both devices are exactly linear in length over the range
* used here (checked at L = 40/80 um and l = 100/600 um).
*   r1 = 38.14k (poly) + 36.19k (ndiff) = 74.33k  -> vth_lo ~ 0.363 V
*   r2 = 89.83k (poly) + 85.30k (ndiff) = 175.13k -> dV     ~ 0.854 V
* Poly fraction 0.5129/0.5131 against the 0.5131 zero-TC target.
.param r1_w=1
.param r1_l=18
.param r1n_w=1
.param r1n_l=308
.param r2_w=1
.param r2_l=42.4
.param r2n_w=1
.param r2n_l=726
* Reference-node decoupling. Both threshold nodes are high-impedance
* (vth_lo ~74 kohm, vth_hi ~250 kohm to ground), so each comparator's
* switching kickback through its own input-pair gate overlap lands
* directly on the threshold it is in the act of crossing. 0.5 pF is ~15x
* the input pair's total gate capacitance at these geometries (W=8, L=0.5
* at ~8 fF/um^2) and orders of magnitude above its gate-drain overlap, so
* the threshold holds still across an edge; the resulting ~37 ns / ~125 ns
* node time constants (plus the compensating sections' own junction
* capacitance, which only slows them further and is likewise settled long
* before the gate) still settle the reference well before the 6 us
* measurement gate in sim_request.json. Undecoupled, the kickback was
* large enough to make an instantaneous threshold reading at
* ff/1.62V/-40C come back 122 mV high -- see README.md.
.param cref=0.5p

Vdd vdd 0 DC {vdd}

* --- shared bias generation (verbatim from ../comparator-core/comparator_core.spice) ---
Iref vdd nbias DC {ib}
XM5b nbias nbias 0 0 sky130_fd_pr__nfet_01v8 L=1 W=10 nf=1 mult=1
Irefp pbias 0 DC {ib}
XM5c pbias pbias vdd vdd sky130_fd_pr__pfet_01v8 L=1 W=40 nf=2 mult=1

* --- device-level vth_lo/vth_hi reference generator ---
XMref vth_hi pbias vdd vdd sky130_fd_pr__pfet_01v8 L=1 W=40 nf=2 mult=1
* r2 leg (sets dV): negative-tempco poly on top, positive-tempco
* n-diffusion below, joined at rmid2.
XRdiv2  vth_hi rmid2  0 sky130_fd_pr__res_xhigh_po   W={r2_w}  L={r2_l}  mult=1 m=1
XRdiv2n rmid2  vth_lo 0 sky130_fd_pr__res_generic_nd w={r2n_w} l={r2n_l}
* r1 leg (sets vth_lo): same construction, joined at rmid1.
XRdiv1  vth_lo rmid1  0 sky130_fd_pr__res_xhigh_po   W={r1_w}  L={r1_l}  mult=1 m=1
XRdiv1n rmid1  0      0 sky130_fd_pr__res_generic_nd w={r1n_w} l={r1n_l}
Crefh vth_hi 0 {cref}
Crefl vth_lo 0 {cref}

* --- NMOS-input comparator: owns the UPPER threshold (verbatim from comparator_core.spice) ---
.subckt cmp_n in vref out vdd nbias
XM5  tail nbias 0 0 sky130_fd_pr__nfet_01v8 L=1 W=10 nf=1 mult=1
XM1  n1   in   tail 0 sky130_fd_pr__nfet_01v8 L=0.5 W=8 nf=1 mult=1
XM2  pout vref tail 0 sky130_fd_pr__nfet_01v8 L=0.5 W=8 nf=1 mult=1
XM3  n1   n1   vdd vdd sky130_fd_pr__pfet_01v8 L=0.5 W=40 nf=2 mult=1
XM4  pout n1   vdd vdd sky130_fd_pr__pfet_01v8 L=0.5 W=40 nf=2 mult=1
XMN6 nb  pout 0   0   sky130_fd_pr__nfet_01v8 L=0.15 W=1 nf=1 mult=1
XMP6 nb  pout vdd vdd sky130_fd_pr__pfet_01v8 L=0.15 W=2 nf=1 mult=1
XMN7 out nb   0   0   sky130_fd_pr__nfet_01v8 L=0.15 W=2 nf=1 mult=1
XMP7 out nb   vdd vdd sky130_fd_pr__pfet_01v8 L=0.15 W=4 nf=1 mult=1
CLo out 0 0.02p
.ends

* --- PMOS-input comparator: owns the LOWER threshold (verbatim from comparator_core.spice) ---
.subckt cmp_p in vref out vdd pbias
XM5  tailp pbias vdd vdd sky130_fd_pr__pfet_01v8 L=1 W=40 nf=2 mult=1
XM1  n1   in    tailp vdd sky130_fd_pr__pfet_01v8 L=0.5 W=40 nf=2 mult=1
XM2  nout vref  tailp vdd sky130_fd_pr__pfet_01v8 L=0.5 W=40 nf=2 mult=1
XM3  n1   n1    0 0 sky130_fd_pr__nfet_01v8 L=0.5 W=10 nf=1 mult=1
XM4  nout n1    0 0 sky130_fd_pr__nfet_01v8 L=0.5 W=10 nf=1 mult=1
XMN6 nb  nout 0   0   sky130_fd_pr__nfet_01v8 L=0.15 W=1 nf=1 mult=1
XMP6 nb  nout vdd vdd sky130_fd_pr__pfet_01v8 L=0.15 W=2 nf=1 mult=1
XMN7 out nb   0   0   sky130_fd_pr__nfet_01v8 L=0.15 W=2 nf=1 mult=1
XMP7 out nb   vdd vdd sky130_fd_pr__pfet_01v8 L=0.15 W=4 nf=1 mult=1
CLo out 0 0.02p
.ends

* -------------------------------------------------------------------
* Comparator input-referred offset injection (issue #2156)
* -------------------------------------------------------------------
* Voffhi/Vofflo are deterministic, input-referred offset generators in
* series with each comparator's vref pin, swept by
* sim_request_startup_offset.json. They follow exactly the
* ".param name=<default> / <source> ... DC {name}" convention
* docs/cli/sim.md's corners.supply_v section documents (the same one
* .param vdd / Vdd already uses here), so a request sweeps them with
* corners.supply_v keys named voffhi/vofflo.
*
* Both default to exactly 0 V. An ideal 0 V source is a short, so with
* the defaults this netlist is electrically identical to the pre-#2156
* one, and that was checked rather than assumed: the full 18-corner
* sim_request.json sweep re-run against this file passes 18/18 with
* every period_avg within 0.41% of the published Evidence table (the
* residual is the sky130A version difference, not this change), and a
* standalone .op against this file returns bit-identical node voltages
* to the same .op against the pre-#2156 file -- which are also #1795's
* published figures to their published precision (ss/1.62V/-40C:
* vo 1.227632 V vs 1.2276, vth_hi 1.221691 V vs 1.2217, q 0.5725938 V
* vs 0.5726).
*
* One caveat worth stating: at ss/1.62V/-40C the DC problem is
* genuinely degenerate, and klt sim's *transient* deck for that corner
* settles on a resolved-latch root rather than the metastable one the
* standalone .op finds. That is a solve-path difference, not a circuit
* difference -- see README.md's "Which side of the knife edge" note.
* It does not affect start-up, which is the whole point.
*
* Sign convention: a POSITIVE voff RAISES the effective threshold the
* comparator actually compares vo against, i.e.
*   v(vth_hi_in) = v(vth_hi) + voffhi
*   v(vth_lo_in) = v(vth_lo) + vofflo
* Injecting at vref rather than at in is the input-referred equivalent of
* a real input-pair Vth/beta mismatch (the quantity a comparator's offset
* spec names), and it leaves the timing node vo undisturbed.
*
* What the sweep found, and why the thin .op margin is not a headroom.
* The natural reading of "vo sits only 1.2-5.9 mV above vth_hi at t=0"
* is that a few mV of comparator offset could close that gap and stop
* cmp_n asserting. Measured, it cannot: the gap is a high-gain feedback
* loop's DC residual, not a static headroom. At the metastable .op,
* cmp_n is in its linear region and the loop (cmp_n -> latch -> charge/
* discharge switches -> vo) holds vo wherever ohi sits mid-rail -- so
* moving the effective threshold moves vo with it. Over voffhi =
* -50..+50 mV at tt/1.62V/27C the .op margin stays 1.48-1.96 mV -- a
* 208x attenuation of the injected offset; 144x at ss/27C and 271x at
* ff/27C. ss/-40C is looser, 9.5x, staying 4.35-14.90 mV on the 8 of
* its 11 rows whose t=0 solve sits on the knife edge at all; the other
* 3 start from an already-resolved latch, which is the easier case.
* (README.md's "Start-up under comparator offset and mismatch" section
* has the full table.) Offset relocates the balance point; it does not
* consume the margin.
.param voffhi=0
.param vofflo=0
Voffhi vth_hi_in vth_hi DC {voffhi}
Vofflo vth_lo_in vth_lo DC {vofflo}

Xhi vo vth_hi_in ohi vdd nbias cmp_n
Xlo vo vth_lo_in olo vdd pbias cmp_p

* --- output edge-combination logic: NOT(olo) inverter + cross-coupled NOR SR latch ---
XINVp olo_b olo vdd vdd sky130_fd_pr__pfet_01v8 L=0.15 W=2 nf=1 mult=1
XINVn olo_b olo 0   0   sky130_fd_pr__nfet_01v8 L=0.15 W=1 nf=1 mult=1
Colo olo_b 0 0.005p

* NOR1: q = NOR(r=olo_b, qb)
XP1a na1  olo_b vdd  vdd sky130_fd_pr__pfet_01v8 L=0.15 W=4 nf=1 mult=1
XP1b q    qb    na1  vdd sky130_fd_pr__pfet_01v8 L=0.15 W=4 nf=1 mult=1
XN1a q    olo_b 0    0   sky130_fd_pr__nfet_01v8 L=0.15 W=1 nf=1 mult=1
XN1b q    qb    0    0   sky130_fd_pr__nfet_01v8 L=0.15 W=1 nf=1 mult=1
Cq q 0 0.005p

* NOR2: qb = NOR(s=ohi, q)
XP2a na2  ohi   vdd  vdd sky130_fd_pr__pfet_01v8 L=0.15 W=4 nf=1 mult=1
XP2b qb   q     na2  vdd sky130_fd_pr__pfet_01v8 L=0.15 W=4 nf=1 mult=1
XN2a qb   ohi   0    0   sky130_fd_pr__nfet_01v8 L=0.15 W=1 nf=1 mult=1
XN2b qb   q     0    0   sky130_fd_pr__nfet_01v8 L=0.15 W=1 nf=1 mult=1
Cqb qb 0 0.005p

* --- charge/discharge current source + timing capacitor ---
XMchg  chgd pbias vdd vdd sky130_fd_pr__pfet_01v8 L=1 W=78 nf=2 mult=1
XSWchg vo   q     chgd vdd sky130_fd_pr__pfet_01v8 L=0.5 W=8 nf=1 mult=1
XMdis  disd nbias 0   0   sky130_fd_pr__nfet_01v8 L=1 W=19.5 nf=1 mult=1
XSWdis vo   q     disd 0   sky130_fd_pr__nfet_01v8 L=0.5 W=8 nf=1 mult=1

Ccap vo 0 {cosc}
Rleak vo 0 1G
