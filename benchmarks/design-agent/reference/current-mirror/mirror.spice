* Reference solution for benchmarks/design-agent/tasks/current-mirror.json.
*
* NMOS current mirror: a diode-connected reference device (Mref) mirrors
* the reference current Iref into the output branch (Mout) at nominally
* 1:1 ratio (matched W/L on both devices). Vout holds the output branch at
* a fixed operating point mid-swing so the mirrored current can be read
* directly as the current through Vout across the whole corner matrix.
*
* Circuit body only -- klt sim appends analysis/control. Real sky130
* devices (sky130_fd_pr__nfet_01v8) via $PDK_ROOT, per docs/cli/sim.md --
* see sim_request.json's "models" field. Device W/L are in microns
* (sky130_fd_pr subckt convention, bare numbers not "u"-suffixed).

.param vdd=1.8
.param iref=50u

Vdd vdd 0 DC {vdd}
Iref vdd ref DC {iref}
XMref ref ref 0 0 sky130_fd_pr__nfet_01v8 L=2 W=10 nf=1 mult=1
XMout out ref 0 0 sky130_fd_pr__nfet_01v8 L=2 W=10 nf=1 mult=1
Vout out 0 DC 0.9
