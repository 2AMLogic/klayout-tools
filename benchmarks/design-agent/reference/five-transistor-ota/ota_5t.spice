* Reference solution for benchmarks/design-agent/tasks/five-transistor-ota.json.
*
* Classic 5-transistor OTA: NMOS differential input pair (M1/M2), PMOS
* current-mirror load (M3/M4) folding one side's drain current onto the
* single-ended output node, NMOS tail current source (M5). The tail's bias
* voltage is generated by an external diode-connected NMOS (M5b) mirroring
* an ideal reference current -- conventionally NOT counted among the "five"
* transistors (it is bias-generation plumbing external to the amplifier
* core, the same convention kb/entries/five-transistor-ota.json's own
* reused netlist follows), and it is what keeps the tail current -- and
* hence gm/gain -- corner-robust: a fixed gate voltage would drift the tail
* current directly with Vt, a diode-connected mirror tracks it out.
*
* Open-loop gain/GBW/phase margin are measured with the standard
* DC-feedback-closes/AC-feedback-opens trick: Lfb is a DC short (forcing
* V(inn)=V(out), so the loop self-biases to its own natural single-ended
* operating point, exactly like cs_amp.spice's Rf feedback trick -- no
* external DC bias voltage needed at the output) but a ~1 GOhm-equivalent
* open circuit at any AC frequency this sweep cares about; Cfb ties inn to
* the (AC-quiet) cm rail, so at AC, inn is held at cm and the single-ended
* input inp alone drives the loop -- open-loop gain -- while at DC the
* Lfb path still finds a stable bias point on its own.
*
* Circuit body only -- klt sim appends analysis/control. bench_nmos/
* bench_pmos come from models.lib.

.param vdd=1.8
.param vcm=0.9
.param ibias=20u

Vdd  vdd 0 DC {vdd}
Vcm  cm  0 DC {vcm}
Vin  inp cm DC 0 AC 1
Iref vdd nbias DC {ibias}
CL   out 0 1p

* DC feedback: closes at DC (Lfb) to self-bias out; opens at AC. Cfb pins
* inn to the AC-quiet cm rail once the DC path's low-frequency roll-off has
* passed, so the AC drive is single-ended at inp only.
Lfb  out inn 1e9
Cfb  inn cm  1e3

* --- tail bias generator (external to the 5T core; see header) ---
M5b nbias nbias 0 0 bench_nmos W=10u L=2u

* --- tail current source (1 of 5) ---
M5  tail nbias 0 0 bench_nmos W=10u L=2u

* --- NMOS differential input pair (2 of 5) ---
M1  n1  inp tail 0 bench_nmos W=20u L=1u
M2  out inn tail 0 bench_nmos W=20u L=1u

* --- PMOS current-mirror load (2 of 5) ---
M3  n1  n1  vdd vdd bench_pmos W=40u L=2u
M4  out n1  vdd vdd bench_pmos W=40u L=2u
