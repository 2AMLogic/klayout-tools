* klayout-tools issue #6903 fixture: two-port inductor2 reference
.SUBCKT IND2 LA LB
L1 LA LB sub inductor w=2u s=2.1u d=25.35u nr_r=1
.ENDS
