# The glitch_filter subckt of 2AMLogic/sky130-droop-detector design/glitch_filter.spice
# (netlist export of design/glitch_filter.sch @ main, klt-netlist-inputs
# header preserved below) -- copied for tests/test_layout_plan_mixed_sky130_block.py
# per issue #6920: a mixed-device block (xhigh res + MIM cap + four 5V hvi
# FETs) whose default routing is that issue's acceptance case.
#
** klt-netlist-inputs: {"pdk_variant": "sky130A", "rcfile": "xschemrc", "xschem_version": "3.4.7"}
** sch_path: /home/ubuntu/GitHub/sky130-droop-detector/.loom/worktrees/issue-77/design/glitch_filter.sch
.subckt glitch_filter flag_in vdd33 gnd flag_f
*.ipin flag_in
*.iopin vdd33
*.iopin gnd
*.opin flag_f
XR1 rc flag_in gnd sky130_fd_pr__res_xhigh_po_1p41 L=3 mult=1 m=1
XC1 rc gnd sky130_fd_pr__cap_mim_m3_1 W=9 L=9 MF=1 m=1
XM1 rcb rc vdd33 vdd33 sky130_fd_pr__pfet_g5v0d10v5 L=0.5 W=2 nf=1 ad=0.58 as=0.58 pd=4.58 ps=4.58 nrd=0.145 nrs=0.145 sa=0 sb=0
+ sd=0 mult=1 m=1
XM2 rcb rc gnd gnd sky130_fd_pr__nfet_g5v0d10v5 L=0.5 W=1 nf=1 ad=0.29 as=0.29 pd=2.58 ps=2.58 nrd=0.29 nrs=0.29 sa=0 sb=0 sd=0
+ mult=1 m=1
XM3 flag_f rcb vdd33 vdd33 sky130_fd_pr__pfet_g5v0d10v5 L=0.5 W=2 nf=1 ad=0.58 as=0.58 pd=4.58 ps=4.58 nrd=0.145 nrs=0.145 sa=0
+ sb=0 sd=0 mult=1 m=1
XM4 flag_f rcb gnd gnd sky130_fd_pr__nfet_g5v0d10v5 L=0.5 W=1 nf=1 ad=0.29 as=0.29 pd=2.58 ps=2.58 nrd=0.29 nrs=0.29 sa=0 sb=0
+ sd=0 mult=1 m=1
.ends
